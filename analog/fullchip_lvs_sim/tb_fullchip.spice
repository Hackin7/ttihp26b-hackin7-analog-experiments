* Full-tile transistor transient from the Magic LVS netlist.
* PDK includes, stimulus, and .control are written by run_sim.sh into out/.
.include out/pdk.lib
.include out/dio.lib
.include out/stdcells.spice
.include out/ring.spice
.include out/chip.spice
.include out/stim.spice

.options reltol=1e-3 vntol=1e-3 abstol=1e-9 chgtol=1e-14 rshunt=1e12

Xdut VGND VPWR clk ena rst_n
+ ui_in_0 ui_in_1 ui_in_2 ui_in_3 ui_in_4 ui_in_5 ui_in_6 ui_in_7
+ uio_in_0 uio_in_1 uio_in_2 uio_in_3 uio_in_4 uio_in_5 uio_in_6 uio_in_7
+ uio_oe_0 uio_oe_1 uio_oe_2 uio_oe_3 uio_oe_4 uio_oe_5 uio_oe_6 uio_oe_7
+ uio_out_0 uio_out_1 uio_out_2 uio_out_3 uio_out_4 uio_out_5 uio_out_6 uio_out_7
+ uo_out_0 uo_out_1 uo_out_2 uo_out_3 uo_out_4 uo_out_5 uo_out_6 uo_out_7
+ tt_um_hackin7_analog_experiments

vvdd VPWR 0 dc 1.2
vvss VGND 0 0
vena ena 0 dc 1.2
vui2 ui_in_2 0 dc 0
vui3 ui_in_3 0 dc 0
vui4 ui_in_4 0 dc 0
vui5 ui_in_5 0 dc 0
vui6 ui_in_6 0 dc 0
vui7 ui_in_7 0 dc 0
vuio0 uio_in_0 0 dc 0
vuio1 uio_in_1 0 dc 0
vuio2 uio_in_2 0 dc 0
vuio3 uio_in_3 0 dc 0
vuio4 uio_in_4 0 dc 0
vuio5 uio_in_5 0 dc 0
vuio6 uio_in_6 0 dc 0
vuio7 uio_in_7 0 dc 0

.include out/analysis.spice
.end
