* ring_oscillator.spice -- SG13G2 ring-, for xschem->ngspice (Part 3 macro)
* Pure analog: each stage is a comparator E-source driving an RC node.
* Delay comes from the physical RC (metal resistor + gate cap), not from
* spurious "td=" syntax (ngspice rejects td passthrus).
*
* 3-stage gated ring:
*   stage1: NAND2 comparator  (a=enable, b=stage3out) -> n1
*   stage2: inv comparator    (n1) -> n2
*   stage3: inv comparator    (n2) -> n3
*   outbuf: buf comparator    (n2) -> clk_out (digital clock feed)
*
* RC values chosen for ~50-200 MHz-class visible oscillation in a 40MHz
* TT-clock-aware transient (this is the *behavioral* sweep; the hardened
* macro timing comes from LVS+parasitic extraction of the SG13G2 layout).

* ------------------ stage 1: NAND2 (enable AND stage3) ----------------
enand1 n1 0 value={ ( (v(enable) > 0.6) && (v(n3) > 0.6) ) ? 1.2 : 0.0 }
rnand1 n1tail 0 2000
cnand1 n1 0 20f
rnand1b n1 n1tail 10

* ------------------ stage 2: inverter ----------------------------------
einv2 n2 0 value={ (v(n1) > 0.6) ? 0.0 : 1.2 }
rinv2 n2tail 0 2000
cinv2 n2 0 20f
rinv2b n2 n2tail 10

* ------------------ stage 3: inverter ----------------------------------
einv3 n3 0 value={ (v(n2) > 0.6) ? 0.0 : 1.2 }
rinv3 n3tail 0 2000
cinv3 n3 0 20f
rinv3b n3 n3tail 10

* ------------------ output buffer --------------------------------------
ebuf clk_out 0 value={ (v(n2) > 0.6) ? 1.2 : 0.0 }
rbuf  clk_out 0 500
cbuf  clk_out 0 50f

* ------------------ testbench ------------------------------------------
vEnable enable 0 1.2

* small init kick so the metastable point breaks cleanly
* (deterministic uic: set n1=0 so stage1 pulls up -> transitions roll)
.ic v(n1)=0 v(n2)=1.2 v(n3)=0
