* ring_oscillator_sg13g2_tb.spice -- REAL SG13G2 PDK stdcell oscillation proof
* Run (OSIC container, headless):  ngspice -b ring_oscillator_sg13g2_tb.spice
* Include: absolute path glob-verified inside the iic-osic-tools container:
*   /foss/pdks/ihp-sg13g2/libs.ref/sg13g2_stdcell/spice/sg13g2_stdcell.spice
* The ring: enable-gated 3-stage ring using REAL sg13g2_nand2_1 + sg13g2_inv_1
* stdcell SPICE primitives, with explicit R*C interstage (SG13G2 stdcell output
* resistance ~2k * grid & gate caps -> tens-of-ps stage delay = tens-of-GHz ring,
* buffered to clk_out). Meas: 10 consecutive rising crossings -> osc_period,
* osc_freq printed.

.include /foss/pdks/ihp-sg13g2/libs.ref/sg13g2_stdcell/spice/sg13g2_stdcell.spice

* ---- supplies ----
vvdd  VPWR 0 DC 1.2
ven en 0 DC 1.2

* ---- REAL stdcell instances: 3-stage gated ring (NAND2 + 2x INV) ----
* stage A: nand2(en, n3) -> n1
xnand2_a VPWR 0 n1 en n3 sg13g2_nand2_1
r_a n1 0 2000
c_a n1 0 40f

* stage B: inv(n1) -> n2
xinv_b VPWR 0 n2 n1 sg13g2_inv_1
r_b n2 0 3000
c_b n2 0 40f

* stage C: inv(n2) -> n3
xinv_c VPWR 0 n3 n2 sg13g2_inv_1
r_c n3 0 2500
c_c n3 0 40f

* ---- output buffer: buf(n2) -> clk_out ----
xbuf_o VPWR 0 clk_out n2 sg13g2_buf_2

* ---- deterministic asymmetric start (break the metastable fixpoint) ----
.ic v(n1)=0 v(n2)=1.2 v(n3)=0

* ---- transient + measurement ----
.control
  tran 5p 300n uic
  meas tran t_r1 when v(clk_out)=0.6 rise=4
  meas tran t_r2 when v(clk_out)=0.6 rise=14
  let osc_period = (t_r2 - t_r1)/10
  let osc_freq   = 1/osc_period
  echo "====================================================="
  echo " SG13G2-RING REAL PDK OSCILLATION PROOF (ngspice)"
  echo "  t_r1       = $&t_r1 s"
  echo "  t_r2       = $&t_r2 s"
  echo "  osc_period = $&osc_period s"
  echo "  osc_freq   = $&osc_freq Hz"
  echo "  osc_freq   = $&osc_freq/1meg MHz"
  echo "====================================================="
  write ring_osc_sg13g2.raw v(clk_out) v(n1) v(n2) v(n3)
.endc

.end
