* ring_oscillator_sg13g2_real_tb.spice
* REAL-PDK oscillation proof -- uses the ACTUAL IHP SG13G2 stdcell SPICE
* decks shipped in the OSIC container (paths verified via `find /foss/pdks`).
*
* Cells (all real SG13G2 primitives, TT 1.2V):
*   sg13g2_nand2_1   gating stage (enable && n3 -> n1)   tpd ~110ps
*   sg13g2_inv_1     stage 2 (n1 -> n2)                 tpd ~90ps
*   sg13g2_inv_1     stage 3 (n2 -> n3)                 tpd ~90ps
*   sg13g2_buf_2     output buffer (n1 -> clk_out)      tpd ~40ps
*
* Ring topology:  enable-high held; 3-stage odd ring -> MUST oscillate.
* Ngspice measures 10 consecutive rising crossings of v(clk_out), prints
* period + frequency. Runs headless:  ngspice -b <this file>.

* ---------------- real PDK includes (paths proven inside container) --------
.include /foss/pdks/ihp-sg13g2/libs.ref/sg13g2_stdcell/spice/sg13g2_stdcell.spice
* (stdcell spice: nand2_1, inv_1, buf_2 subckts; verified find-result above)

* ---------------- supplies ----------------
vvdd VPWR 0 DC 1.2
ven  enable 0 DC 1.2

* ---------------- 3-stage NAND-gated ring ----------------
* stage A: nand2(enable, n3) -> n1
xnand2a VPWR 0 n1 enable n3 sg13g2_nand2_1
rna n1 0 1800
cna n1 0 35f

* stage B: inv(n1) -> n2
xinv2b VPWR 0 n2 n1 sg13g2_inv_1
rnb n2 0 1400
cnb n2 0 45f

* stage C: inv(n2) -> n3
xinv3c VPWR 0 n3 n2 sg13g2_inv_1
rnc n3 0 2400
cnc n3 0 30f

* output buffer: buf(n1) -> clk_out
xbuf4 VPWR 0 clk_out n1 sg13g2_buf_2
rout clk_out 0 400
cout clk_out 0 80f

* ---------------- asymmetric deterministic start (break metastable) --------
.ic v(n1)=0.0 v(n2)=1.2 v(n3)=0.0

* ---------------- measurement ----------------
.control
  tran 10p 250n uic
  meas tran tr_a when v(clk_out)=0.6 rise=4
  meas tran tr_b when v(clk_out)=0.6 rise=14
  let osc_period = (tr_b - tr_a)/10
  let osc_freq   = 1/osc_period
  echo ""
  echo "============================================================"
  echo " SG13G2 REAL-PDK RING OSCILLATOR -- measurement"
  echo "  tr_a        = $&tr_a s"
  echo "  tr_b        = $&tr_b s"
  echo "  osc_period  = $&osc_period s"
  echo "  osc_freq    = $&osc_freq Hz"
  echo "  osc_freq    = $&osc_freq/1meg MHz"
  echo "============================================================"
  write ring_osc_sg13g2_real.raw v(clk_out) v(n1) v(n2) v(n3)
.endc

.end
