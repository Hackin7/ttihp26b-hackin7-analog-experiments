* ring_oscillator_sg13g2.spice
* Part 3 analog macro -- 3-stage gated ring using REAL IHP SG13G2 stdcell
* SPICE subckts (from the OSIC PDK install), NOT behavioral e-sources.
*
* Cells used (SG13G2 typ, 1.2V, TT):
*   sg13g2_nand2_1  (enable gate, ~110ps tpd)
*   sg13g2_inv_1    (stage, ~90ps tpd)
*   sg13g2_buf_2    (output buffer, clk_out)
*
* Pin order follows the IHP PDK stdcell subckt convention:
*   sg13g2_nand2_1:  .subckt sg13g2_nand2_1 VPWR VGND Y A B
*   sg13g2_inv_1:    .subckt sg13g2_inv_1   VPWR VGND Y A
*   sg13g2_buf_2:    .subckt sg13g2_buf_2   VPWR VGND Y A
*
* Macro pin contract (matches tt_analog DEF + project.v black box):
*   clk_out  enable   [power:  VPWR VGND]

.subckt ring_oscillator_macro VPWR VGND clk_out enable

* stage A: NAND2 gate (enable && stageC_out) -> n1
x_nandA  VPWR VGND n1  enable n3  sg13g2_nand2_1

* stage B: inv(n1) -> n2
x_invB   VPWR VGND n2  n1  sg13g2_inv_1

* stage C: inv(n2) -> n3
x_invC   VPWR VGND n3  n2  sg13g2_inv_1

* output buffer: buf(n2) -> clk_out
x_outbuf VPWR VGND clk_out n2 sg13g2_buf_2

.ends ring_oscillator_macro

.end
