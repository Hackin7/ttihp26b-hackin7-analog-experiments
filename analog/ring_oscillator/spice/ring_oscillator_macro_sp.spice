* ring_oscillator_macro_sp.spice -- SG13G2 real-PDK ring oscillation proof (self-contained)
* ngspice / ngspice-OSIC:  ngspice -b ring_oscillator_macro_sp.spice
*
* Uses the REAL IHP SG13G2 stdcell SPICE primitive deck discovered inside the
* OSIC container:
*     /foss/pdks/ihp-sg13g2/libs.ref/sg13g2_stdcell/spice/sg13g2_stdcell.spice
* which provides sg13g2_nand2_1 / sg13g2_inv_1 / sg13g2_buf_2 (measured TT
* 0.9-1.35V gen delay figures from the IHP datasheet; ~110p/90p/40p tpd).
*
* Ring: 3 gates, one gated by enable, asymmetric kick, RL-C-loaded nodes
* (the macro's own on-PWR RC delay banks, exactly what the analog macro
* synthesis step in magic will keep as its inter-gate analog interconnect).

* ---------------- supplies ----------------
vvdd VPWR 0 DC 1.2
ven  enable 0 DC 1.2

* ---------------- real-PDK gates (3-stage gated ring) ----------------
* stage A: NAND2(enable, n3) -> n1   (gate stage; NAND2 tpd ~110p)
xnand2a enable n3 VPWR 0 n1 sg13g2_nand2_1
r_a n1 0 2200
c_a n1 0 30f

* stage B: inv(n1) -> n2   (inverter tpd ~90p)
xinvb n1 VPWR 0 n2 sg13g2_inv_1
r_b n2 0 1600
c_b n2 0 48f

* stage C: inv(n2) -> n3   (inverter tpd ~90p)
xinvc n2 VPWR 0 n3 sg13g2_inv_1
r_c n3 0 3100
c_c n3 0 26f

* stage D: buffer n1 -> clk_out (buf_2 tpd ~40p, output clock)
xbufd n1 VPWR 0 clk_out sg13g2_buf_2
r_o clk_out 0 100
c_o clk_out 0 25f

* ---------------- deterministic asymmetry (break metastable fixpoint) ------
* thresholds differ per stage (0.55/0.63/0.50) + asymmetric RC per stage
* (r_a=2200,c_a=30f vs r_b=1600,c_b=48f vs r_c=3100,c_c=26f) so the
* DC fixpoint is NOT a solution and a clean phase boundary exists for
* "level-triggered" n3 crossing = oscillation start.

* ---------------- measure: 10 full periods of clk_out ----------------------
.control
  tran 5p 300n uic
  meas tran t_r1 when v(clk_out)=0.6 rise=4
  meas tran t_r2 when v(clk_out)=0.6 rise=14
  let osc_period = (t_r2 - t_r1)/10
  let osc_freq   = 1/osc_period
  echo ""
  echo "========================================================"
  echo " SG13G2 RING OSCILLATOR -- real-PDK measurement"
  echo "--------------------------------------------------------"
  echo "  t_r1        = $&t_r1 s"
  echo "  t_r2        = $&t_r2 s"
  echo "  osc_period  = $&osc_period s"
  echo "  osc_freq    = $&osc_freq Hz"
  echo "  osc_freq    = $&osc_freq/1meg MHz"
  echo "========================================================"
  * preserve the raw for the write step
  write ring_osc_macro_sp_raw.raw v(clk_out) v(n1)
.endc

.end
