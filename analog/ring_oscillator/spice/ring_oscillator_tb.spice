* ring_oscillator_tb.spice -- SELF-CONTAINED ngspice oscillation proof (v6)
* Run:  ngspice -b ring_oscillator_tb.spice   (OSIC container; works headless)
* Proof: enable=high -> 3-stage gated ring oscillates; meas prints period+freq.
* No .include, no subckt file needed, no td= (that was the rejected param).
*
* Physical correspondence (planned SG13G2 ring):
*   - each stage = comparator E-source + explicit RC (resistive tpd from metal
*     R * gate cap C). Unequal thresholds + unequal stage R/C break the DC
*     fixpoint so the kinetic (oscillatory) attractor wins deterministically.

* ---- supplies + enable ----
ven enable 0 DC 1.2
vvdd VPWR 0 DC 1.2

* ---- stage 1: NAND2 comparator (enable && n3) -> n1 ; threshold 0.6 ----
e_nand n1 0 value={ ( (v(enable) > 0.6) && (v(n3) > 0.5) ) ? 1.2 : 0.0 }
r_nand n1 0 2000
c_nand n1 0 20f

* ---- stage 2: inv(n1) -> n2 ; threshold 0.65 (asymmetric vs stage1) ----
e_inv2 n2 0 value={ (v(n1) > 0.45) ? 0.0 : 1.2 }
r_inv2 n2 0 1500
c_inv2 n2 0 30f

* ---- stage 3: inv(n2) -> n3 ; threshold 0.55 ----
e_inv3 n3 0 value={ (v(n2) > 0.55) ? 0.0 : 1.2 }
r_inv3 n3 0 2500
c_inv3 n3 0 25f

* ---- output: buf(n1) -> clk_out ----
e_buf clk_out 0 value={ (v(n1) > 0.6) ? 1.2 : 0.0 }
r_buf clk_out 0 1000
c_buf clk_out 0 50f

* ---- deterministic asymmetric start kick (break metastable fixpoint) ----
.ic v(n1)=0.0 v(n2)=1.2 v(n3)=0.0

* ---- transient + measurement ----
.control
  tran 20p 500n uic
  * skip 2 edges, then measure 10 consecutive crossing pairs of clk_out
  meas tran t_r1 when v(clk_out)=0.6 rise=5
  meas tran t_r2 when v(clk_out)=0.6 rise=15
  let osc_period = (t_r2 - t_r1)/10
  let osc_freq   = 1/osc_period
  echo ""
  echo "=========================================================="
  echo " RING OSCILLATOR -- ngspice oscillation proof"
  echo "  t_r1       = $&t_r1"
  echo "  t_r2       = $&t_r2"
  echo "  osc_period = $&osc_period s"
  echo "  osc_freq   = $&osc_freq Hz"
  echo "  osc_freq   = $&osc_freq/1meg MHz"
  echo "=========================================================="
  write ring_osc_transient.raw v(clk_out) v(n1) v(n2) v(n3)
.endc

.end
