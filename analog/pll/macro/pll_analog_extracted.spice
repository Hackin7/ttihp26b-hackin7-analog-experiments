* NGSPICE file created from pll_analog.ext - technology: ihp-sg13g2

.subckt sg13g2_dfrbpq_1 VDD D Q CLK VSS RESET_B a_741_93# a_843_236# a_38_114# a_324_432#
+ a_298_337#
X0 VDD RESET_B a_298_337# VDD sg13_lv_pmos ad=0.1563p pd=1.22u as=0.147p ps=1.54u w=0.42u l=0.13u
X1 VSS RESET_B a_132_114# VSS sg13_lv_nmos ad=0.1626p pd=1.415u as=60.89999f ps=0.71u w=0.42u l=0.13u
X2 a_550_127# RESET_B VSS VSS sg13_lv_nmos ad=37.8f pd=0.6u as=0.1701p ps=1.65u w=0.42u l=0.13u
X3 a_298_337# a_741_93# a_681_505# VDD sg13_lv_pmos ad=79.8f pd=0.8u as=63f ps=0.72u w=0.42u l=0.13u
X4 a_1840_334# a_1583_191# a_2002_114# VSS sg13_lv_nmos ad=0.1428p pd=1.52u as=37.8f ps=0.6u w=0.42u l=0.13u
X5 a_38_114# a_843_236# a_298_337# VDD sg13_lv_pmos ad=0.1428p pd=1.52u as=79.8f ps=0.8u w=0.42u l=0.13u
X6 a_741_93# CLK VSS VSS sg13_lv_nmos ad=0.2516p pd=2.16u as=2.26778p ps=14.665u w=0.74u l=0.13u
X7 a_38_114# D VDD VDD sg13_lv_pmos ad=79.8f pd=0.8u as=0.1428p ps=1.52u w=0.42u l=0.13u
X8 a_741_93# CLK VDD VDD sg13_lv_pmos ad=0.4088p pd=2.97u as=1.12285p ps=7.26u w=1.12u l=0.13u
X9 VSS a_741_93# a_843_236# VSS sg13_lv_nmos ad=2.26778p pd=14.665u as=0.2516p ps=2.16u w=0.74u l=0.13u
X10 VSS a_1840_334# a_1489_191# VSS sg13_lv_nmos ad=79.8f pd=0.8u as=0.1428p ps=1.52u w=0.42u l=0.13u
X11 VDD RESET_B a_38_114# VDD sg13_lv_pmos ad=0.36237p pd=2.605u as=79.8f ps=0.8u w=0.42u l=0.13u
X12 a_324_432# a_298_337# VSS VSS sg13_lv_nmos ad=0.2516p pd=2.16u as=0.1626p ps=1.415u w=0.74u l=0.13u
X13 VDD a_741_93# a_843_236# VDD sg13_lv_pmos ad=1.12285p pd=7.26u as=0.3864p ps=2.93u w=1.12u l=0.13u
X14 a_2002_114# RESET_B VSS VSS sg13_lv_nmos ad=37.8f pd=0.6u as=79.8f ps=0.8u w=0.42u l=0.13u
X15 VDD a_1583_191# a_2250_412# VDD sg13_lv_pmos ad=0.2128p pd=1.5u as=0.3864p ps=2.93u w=1.12u l=0.13u
X16 Q a_2250_412# VDD VDD sg13_lv_pmos ad=0.3808p pd=2.92u as=0.2128p ps=1.5u w=1.12u l=0.13u
X17 a_132_114# D a_38_114# VSS sg13_lv_nmos ad=60.89999f pd=0.71u as=0.1428p ps=1.52u w=0.42u l=0.13u
X18 a_1785_429# a_843_236# a_1583_191# VDD sg13_lv_pmos ad=93.45f pd=0.865u as=0.2048p ps=1.63u w=0.42u l=0.13u
X19 VDD a_1583_191# a_1840_334# VDD sg13_lv_pmos ad=1.12285p pd=7.26u as=79.8f ps=0.8u w=0.42u l=0.13u
X20 a_1583_191# a_741_93# a_324_432# VDD sg13_lv_pmos ad=0.2048p pd=1.63u as=0.34p ps=2.68u w=1u l=0.13u
X21 a_1583_191# a_741_93# a_1489_191# VSS sg13_lv_nmos ad=0.12665p pd=1.145u as=0.1428p ps=1.52u w=0.42u l=0.13u
X22 VDD a_1840_334# a_1785_429# VDD sg13_lv_pmos ad=1.12285p pd=7.26u as=93.45f ps=0.865u w=0.42u l=0.13u
X23 a_1840_334# RESET_B VDD VDD sg13_lv_pmos ad=79.8f pd=0.8u as=1.12285p ps=7.26u w=0.42u l=0.13u
X24 a_324_432# a_843_236# a_1583_191# VSS sg13_lv_nmos ad=0.3473p pd=2.71u as=0.12665p ps=1.145u w=0.74u l=0.13u
X25 a_298_337# a_741_93# a_38_114# VSS sg13_lv_nmos ad=79.8f pd=0.8u as=0.1296p ps=1.52u w=0.42u l=0.13u
X26 a_612_127# a_324_432# a_550_127# VSS sg13_lv_nmos ad=0.1428p pd=1.52u as=37.8f ps=0.6u w=0.42u l=0.13u
X27 a_681_505# a_324_432# VDD VDD sg13_lv_pmos ad=63f pd=0.72u as=0.1563p ps=1.22u w=0.42u l=0.13u
X28 a_612_127# a_843_236# a_298_337# VSS sg13_lv_nmos ad=0.2373p pd=1.97u as=79.8f ps=0.8u w=0.42u l=0.13u
X29 VSS a_1583_191# a_2250_412# VSS sg13_lv_nmos ad=0.1406p pd=1.12u as=0.2516p ps=2.16u w=0.74u l=0.13u
X30 a_324_432# a_298_337# VDD VDD sg13_lv_pmos ad=0.34p pd=2.68u as=0.36237p ps=2.605u w=1u l=0.13u
X31 Q a_2250_412# VSS VSS sg13_lv_nmos ad=0.2516p pd=2.16u as=0.1406p ps=1.12u w=0.74u l=0.13u
.ends

.subckt sg13g2_and2_1 X VSS VDD B A a_45_160#
X0 X a_45_160# VDD VDD sg13_lv_pmos ad=0.3808p pd=2.92u as=0.1918p ps=1.5u w=1.12u l=0.13u
X1 X a_45_160# VSS VSS sg13_lv_nmos ad=0.2516p pd=2.16u as=0.1331p ps=1.12u w=0.74u l=0.13u
X2 a_45_160# A VDD VDD sg13_lv_pmos ad=0.1596p pd=1.22u as=0.2856p ps=2.36u w=0.84u l=0.13u
X3 VDD B a_45_160# VDD sg13_lv_pmos ad=0.1918p pd=1.5u as=0.1596p ps=1.22u w=0.84u l=0.13u
X4 a_139_160# A a_45_160# VSS sg13_lv_nmos ad=0.1216p pd=1.02u as=0.2176p ps=1.96u w=0.64u l=0.13u
X5 VSS B a_139_160# VSS sg13_lv_nmos ad=0.1331p pd=1.12u as=0.1216p ps=1.02u w=0.64u l=0.13u
.ends

.subckt sg13g2_inv_1 Y A VSS VDD
X0 Y A VDD VDD sg13_lv_pmos ad=0.3808p pd=2.92u as=0.3808p ps=2.92u w=1.12u l=0.13u
X1 Y A VSS VSS sg13_lv_nmos ad=0.2516p pd=2.16u as=0.2516p ps=2.16u w=0.74u l=0.13u
.ends

.subckt rhigh_R1_snake B R1 R2
X0 R1 R1 B rhigh l=0.15044m w=0.16382m
.ends

.subckt sg13_lv_pmos_NJKCVT D S G
X0 S G D w_n155_n174# sg13_lv_pmos ad=0.3808p pd=2.92u as=0.3808p ps=2.92u w=1.12u l=0.25u
.ends

.subckt rhigh_R2_snake B R1 R2
X0 R1 R1 B rhigh l=0.54004m w=0.16382m
.ends

.subckt sg13_lv_nmos_RUYN9Y D S G sub
X0 S G D sub sg13_lv_nmos ad=0.2516p pd=2.16u as=0.2516p ps=2.16u w=0.74u l=0.25u
.ends

.subckt sg13_lv_pmos_ESLPQL D S G
X0 S G D w_n230_n162# sg13_lv_pmos ad=0.34p pd=2.68u as=0.34p ps=2.68u w=1u l=1u
.ends

.subckt sg13_lv_nmos_VQD2M8 D S G sub
X0 S G D sub sg13_lv_nmos ad=0.17p pd=1.68u as=0.17p ps=1.68u w=0.5u l=0.13u
.ends

.subckt sg13_lv_pmos_XN8759 D S G
X0 S G D w_n143_n112# sg13_lv_pmos ad=0.17p pd=1.68u as=0.17p ps=1.68u w=0.5u l=0.13u
.ends

.subckt sg13_lv_nmos_WRM2S2 D S G sub
X0 S G D sub sg13_lv_nmos ad=0.17p pd=1.68u as=0.17p ps=1.68u w=0.5u l=1u
.ends

.subckt cap_cmim_4SFK5Q C1 C2
X0 C1 C2 cap_cmim l=20u w=20u
.ends

.subckt cap_cmim_ZNKAVF C1 C2
X0 C1 C2 cap_cmim l=8u w=8u
.ends

.subckt pll_analog VGND out
Xx1 out out out out out out out out out out out sg13g2_dfrbpq_1
Xx3 out out out out out out sg13g2_and2_1
Xx2 out out out out out out out out out out out sg13g2_dfrbpq_1
Xx4 out out out out sg13g2_inv_1
XXR1 out out out rhigh_R1_snake
XXMp1 out out out sg13_lv_pmos_NJKCVT
XXR2 out XR2/R1 out rhigh_R2_snake
XXMp2 out out out sg13_lv_pmos_NJKCVT
XXMp3 out out out sg13_lv_pmos_NJKCVT
XXMn1 out out out out sg13_lv_nmos_RUYN9Y
XXMp4 out out out sg13_lv_pmos_NJKCVT
XXMn2 out out out out sg13_lv_nmos_RUYN9Y
XXM1 out out out sg13_lv_pmos_ESLPQL
XXMn4 out out out out sg13_lv_nmos_RUYN9Y
XXMp5 out out out sg13_lv_pmos_NJKCVT
XXMp6 out out out sg13_lv_pmos_NJKCVT
XXMn3 out out out out sg13_lv_nmos_RUYN9Y
XXM2 out out out out sg13_lv_nmos_VQD2M8
XXMp7 out out out sg13_lv_pmos_NJKCVT
XXMn5 out out out out sg13_lv_nmos_RUYN9Y
XXM3 out out out sg13_lv_pmos_XN8759
XXMn6 out out out out sg13_lv_nmos_RUYN9Y
XXMp8 out out out sg13_lv_pmos_NJKCVT
XXM4 out out out out sg13_lv_nmos_WRM2S2
XXMn7 out out out out sg13_lv_nmos_RUYN9Y
XXM5 out out out out sg13_lv_nmos_WRM2S2
XXMn8 out out out out sg13_lv_nmos_RUYN9Y
XXM6 out out out out sg13_lv_nmos_WRM2S2
XXM7 out out out sg13_lv_pmos_ESLPQL
XXC1 XC1/C1 XC1/C2 cap_cmim_4SFK5Q
XXC2 XC2/C1 out cap_cmim_ZNKAVF
.ends
