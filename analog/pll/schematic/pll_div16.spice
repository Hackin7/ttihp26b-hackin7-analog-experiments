* CMOS-ish rising-edge TFF (switch sample of ~Q) for ripple counters.
.subckt tff q clk VPWR VGND
Bq qb 0 V = '1.2 - v(q)'
Ced clk ed 20f
Red ed 0 2k
S1 qb q ed 0 tsw
.model tsw sw(vt=0.4 vh=0.05 ron=200 roff=1e12)
Rq q 0 200k
Cq q 0 5f
.ends tff

.subckt pll_div16 clk_in clk_div VPWR VGND
Xt1 q1 clk_in VPWR VGND tff
Xt2 q2 q1     VPWR VGND tff
Xt3 q3 q2     VPWR VGND tff
Xt4 clk_div q3 VPWR VGND tff
.ends pll_div16
