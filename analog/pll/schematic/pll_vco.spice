* 3-stage current-starved VCO matching analog/pll/schematic/pll_top.sch
* Ports: out vctrl enb VPWR VGND  (enb unused: tie 0 for run)
* Default lch=0.25u targets ~1.1 GHz class (pre-layout).
.subckt pll_vco out vctrl VPWR VGND lch=0.25u
* Bias replica: Mn8 gated by vctrl, Mp8 diode -> vbp
Xmn8 n_bias vctrl VGND VGND sg13_lv_nmos w=0.74u l={lch} ng=1 m=1
Xmp8 n_bias n_bias VPWR VPWR sg13_lv_pmos w=1.12u l={lch} ng=1 m=1
* Stage 0: in=o2 out=o0
Xmp7 vs0 n_bias VPWR VPWR sg13_lv_pmos w=1.12u l={lch} ng=1 m=1
Xmp3 o0 o2 vs0 VPWR sg13_lv_pmos w=1.12u l={lch} ng=1 m=1
Xmn3 o0 o2 nt0 VGND sg13_lv_nmos w=0.74u l={lch} ng=1 m=1
Xmn7 nt0 vctrl VGND VGND sg13_lv_nmos w=0.74u l={lch} ng=1 m=1
* Stage 1: in=o0 out=o1
Xmp6 vs1 n_bias VPWR VPWR sg13_lv_pmos w=1.12u l={lch} ng=1 m=1
Xmp1 o1 o0 vs1 VPWR sg13_lv_pmos w=1.12u l={lch} ng=1 m=1
Xmn1 o1 o0 nt1 VGND sg13_lv_nmos w=0.74u l={lch} ng=1 m=1
Xmn5 nt1 vctrl VGND VGND sg13_lv_nmos w=0.74u l={lch} ng=1 m=1
* Stage 2: in=o1 out=o2
Xmp5 vs2 n_bias VPWR VPWR sg13_lv_pmos w=1.12u l={lch} ng=1 m=1
Xmp2 o2 o1 vs2 VPWR sg13_lv_pmos w=1.12u l={lch} ng=1 m=1
Xmn2 o2 o1 nt2 VGND sg13_lv_nmos w=0.74u l={lch} ng=1 m=1
Xmn6 nt2 vctrl VGND VGND sg13_lv_nmos w=0.74u l={lch} ng=1 m=1
* Buffer
Xmp4 out o2 VPWR VPWR sg13_lv_pmos w=1.12u l={lch} ng=1 m=1
Xmn4 out o2 VGND VGND sg13_lv_nmos w=0.74u l={lch} ng=1 m=1
.ends pll_vco
