* Charge pump (~1 uA) + type-II filter for pll_top (sim deck).
* up_b: active-low UP (PMOS switch gate). dn: active-high DN.
.subckt pll_cp_filt up_b dn vctrl VPWR VGND
* --- bias ---
Rbias VPWR vbn 700k
Xmn_ref vbn vbn VGND VGND sg13_lv_nmos w=0.5u l=1.0u ng=1 m=1
Xmn_p vbp vbn VGND VGND sg13_lv_nmos w=0.5u l=1.0u ng=1 m=1
Xmp_ref vbp vbp VPWR VPWR sg13_lv_pmos w=1.0u l=1.0u ng=1 m=1
* --- CP stack ---
Xm1 net7 vbp VPWR VPWR sg13_lv_pmos w=1.0u l=1.0u ng=1 m=1
Xm3 vctrl up_b net7 VPWR sg13_lv_pmos w=0.5u l=0.13u ng=1 m=1
Xm2 vctrl dn net6 VGND sg13_lv_nmos w=0.5u l=0.13u ng=1 m=1
Xm4 net6 vbn VGND VGND sg13_lv_nmos w=0.5u l=1.0u ng=1 m=1
* --- loop filter: R~191k (rhigh 0.5x70), C1~0.6p, C2~0.1p ---
Rr1 vctrl vz 191k
Cc1 vz VGND 0.6p
Cc2 vctrl VGND 0.1p
.ends pll_cp_filt
