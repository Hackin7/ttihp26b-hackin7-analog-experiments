* LVS / Magic gold for pll_top — derived from xschem pll_top.sch netlist.
* Cleaned: bulk ties to VPWR/VGND, classic PFD D=VPWR, clk_fb=vco_out_div.
* Ports match sch: clk_ref_gate vco_out_div out VPWR VGND
.subckt pll_top clk_ref_gate vco_out_div out VPWR VGND

* --- PFD (IHP stdcells as in sch) ---
* dfrbpq_1: Q CLK D RESET_B VDD VSS
Xx1 pfd_up   clk_ref_gate VPWR n_rst VPWR VGND sg13g2_dfrbpq_1
Xx2 pfd_down vco_out_div  VPWR n_rst VPWR VGND sg13g2_dfrbpq_1
Xx3 n_rst pfd_down pfd_up VPWR VGND sg13g2_and2_1
Xx4 up_b pfd_up VPWR VGND sg13g2_inv_1

* --- CP stack (M1..M4) ---
XM1 net4 vbp VPWR VPWR sg13_lv_pmos w=1.0u l=1.0u ng=1 m=1
XM3 vctrl up_b net4 VPWR sg13_lv_pmos w=0.5u l=0.13u ng=1 m=1
XM2 vctrl pfd_down net3 VGND sg13_lv_nmos w=0.5u l=0.13u ng=1 m=1
XM4 net3 vbn VGND VGND sg13_lv_nmos w=0.5u l=1.0u ng=1 m=1

* --- CP bias (M5..M7 + R2) ---
XR2 VPWR vbn VGND rhigh w=0.50e-6 l=260.0e-6 m=1
XM6 vbn vbn VGND VGND sg13_lv_nmos w=0.5u l=1.0u ng=1 m=1
XM5 vbp vbn VGND VGND sg13_lv_nmos w=0.5u l=1.0u ng=1 m=1
XM7 vbp vbp VPWR VPWR sg13_lv_pmos w=1.0u l=1.0u ng=1 m=1

* --- Loop filter ---
XR1 vctrl vz VGND rhigh w=0.50e-6 l=70.0e-6 m=1
XC1 vz VGND cap_cmim w=20.0e-6 l=20.0e-6 m=1
XC2 vctrl VGND cap_cmim w=8.0e-6 l=8.0e-6 m=1

* --- VCO bias replica ---
XMn8 n_bias vctrl VGND VGND sg13_lv_nmos w=0.74u l=0.25u ng=1 m=1
XMp8 n_bias n_bias VPWR VPWR sg13_lv_pmos w=1.12u l=0.25u ng=1 m=1

* --- VCO stage 0: in=o2 out=o0 ---
XMp7 vs0 n_bias VPWR VPWR sg13_lv_pmos w=1.12u l=0.25u ng=1 m=1
XMp3 o0 o2 vs0 VPWR sg13_lv_pmos w=1.12u l=0.25u ng=1 m=1
XMn3 o0 o2 nt0 VGND sg13_lv_nmos w=0.74u l=0.25u ng=1 m=1
XMn7 nt0 vctrl VGND VGND sg13_lv_nmos w=0.74u l=0.25u ng=1 m=1

* --- VCO stage 1: in=o0 out=o1 ---
XMp6 vs1 n_bias VPWR VPWR sg13_lv_pmos w=1.12u l=0.25u ng=1 m=1
XMp1 o1 o0 vs1 VPWR sg13_lv_pmos w=1.12u l=0.25u ng=1 m=1
XMn1 o1 o0 nt1 VGND sg13_lv_nmos w=0.74u l=0.25u ng=1 m=1
XMn5 nt1 vctrl VGND VGND sg13_lv_nmos w=0.74u l=0.25u ng=1 m=1

* --- VCO stage 2: in=o1 out=o2 ---
XMp5 vs2 n_bias VPWR VPWR sg13_lv_pmos w=1.12u l=0.25u ng=1 m=1
XMp2 o2 o1 vs2 VPWR sg13_lv_pmos w=1.12u l=0.25u ng=1 m=1
XMn2 o2 o1 nt2 VGND sg13_lv_nmos w=0.74u l=0.25u ng=1 m=1
XMn6 nt2 vctrl VGND VGND sg13_lv_nmos w=0.74u l=0.25u ng=1 m=1

* --- VCO buffer ---
XMp4 out o2 VPWR VPWR sg13_lv_pmos w=1.12u l=0.25u ng=1 m=1
XMn4 out o2 VGND VGND sg13_lv_nmos w=0.74u l=0.25u ng=1 m=1

.ends pll_top
