* Open-loop VCO through pll_top: force internal vctrl (set via .param).
* Used to hit 800 MHz / 1.1 GHz points.
.include out/pdk.lib
.include ../schematic/pll_top.spice

.param vctrl_dc=0.72

Xpll clk_ref fb VGND out VPWR pll_top
Vvdd VPWR 0 dc 1.2
Vvss VGND 0 0
* Hold PFD quiet; measure ring through leaf
Vref clk_ref 0 dc 0
Vfb  fb 0 dc 0
Vvctrl Xpll.vctrl 0 dc {vctrl_dc}

* Seed ring so UIC starts oscillation
.ic v(Xpll.net6)=1.2 v(Xpll.net7)=0 v(Xpll.net9)=0.6 v(out)=0

.control
  tran 2p 80n uic
  write out/vco.raw v(out) v(Xpll.vctrl) v(Xpll.net6)
  meas tran t2 when v(out)=0.6 rise=10 from=10n to=80n
  meas tran t22 when v(out)=0.6 rise=50 from=10n to=80n
  let period = (t22 - t2)/40
  let freq = 1/period
  print period freq
  echo freq_hz = $&freq
.endc
.end
